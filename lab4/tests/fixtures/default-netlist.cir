* Common-emitter amplifier (voltage-divider bias)
* generated by transistor-simulator; all values are SI units
VCC vcc 0 12
R1 vcc base 100000
R2 base 0 22000
RC vcc coll 2200
RE emi 0 1000
Q1 coll base emi QNPN
C1 in base 1e-06
C2 coll out 1e-06
CE emi 0 0.0001
RL out 0 10000
VIN in 0 DC 0 AC 1 SIN(0 0.01 1000)
.model QNPN NPN(IS=1e-14 BF=100)
.control
set wr_singlescale
set wr_vecnames
op
wrdata op.txt v(vcc) v(base) v(coll) v(emi) i(VCC)
ac dec 10 10 100000
wrdata ac.txt vdb(out) vp(out)
tran 5e-06 0.005
wrdata tran.txt v(in) v(out)
quit
.endc
.end
